* NGSPICE file created from adder4_layout.ext - technology: sky130A

.subckt sky130_fd_sc_hd__xor2_1 A B VGND VNB VPB VPWR X
X0 X a_35_297# a_285_297# VPB sky130_fd_pr__pfet_01v8_hvt ad=0.3 pd=2.6 as=0.26 ps=2.52 w=1 l=0.15
X1 X B a_285_47# VNB sky130_fd_pr__nfet_01v8 ad=0.25025 pd=1.42 as=0.08775 ps=0.92 w=0.65 l=0.15
X2 a_35_297# B VGND VNB sky130_fd_pr__nfet_01v8 ad=0.08775 pd=0.92 as=0.169 ps=1.82 w=0.65 l=0.15
X3 a_117_297# B a_35_297# VPB sky130_fd_pr__pfet_01v8_hvt ad=0.135 pd=1.27 as=0.26 ps=2.52 w=1 l=0.15
X4 VPWR B a_285_297# VPB sky130_fd_pr__pfet_01v8_hvt ad=0.26 pd=2.52 as=0.135 ps=1.27 w=1 l=0.15
X5 VGND A a_35_297# VNB sky130_fd_pr__nfet_01v8 ad=0.08775 pd=0.92 as=0.08775 ps=0.92 w=0.65 l=0.15
X6 VGND a_35_297# X VNB sky130_fd_pr__nfet_01v8 ad=0.208 pd=1.94 as=0.25025 ps=1.42 w=0.65 l=0.15
X7 a_285_297# A VPWR VPB sky130_fd_pr__pfet_01v8_hvt ad=0.135 pd=1.27 as=0.135 ps=1.27 w=1 l=0.15
X8 VPWR A a_117_297# VPB sky130_fd_pr__pfet_01v8_hvt ad=0.135 pd=1.27 as=0.135 ps=1.27 w=1 l=0.15
X9 a_285_47# A VGND VNB sky130_fd_pr__nfet_01v8 ad=0.08775 pd=0.92 as=0.08775 ps=0.92 w=0.65 l=0.15
.ends

.subckt sky130_fd_sc_hd__and2_1 A B VGND VNB VPB VPWR X
X0 VPWR B a_59_75# VPB sky130_fd_pr__pfet_01v8_hvt ad=0.16655 pd=1.39 as=0.0567 ps=0.69 w=0.42 l=0.15
X1 X a_59_75# VPWR VPB sky130_fd_pr__pfet_01v8_hvt ad=0.475 pd=2.95 as=0.16655 ps=1.39 w=1 l=0.15
X2 VGND B a_145_75# VNB sky130_fd_pr__nfet_01v8 ad=0.1118 pd=1.04 as=0.0567 ps=0.69 w=0.42 l=0.15
X3 a_59_75# A VPWR VPB sky130_fd_pr__pfet_01v8_hvt ad=0.0567 pd=0.69 as=0.1176 ps=1.4 w=0.42 l=0.15
X4 X a_59_75# VGND VNB sky130_fd_pr__nfet_01v8 ad=0.182 pd=1.86 as=0.1118 ps=1.04 w=0.65 l=0.15
X5 a_145_75# A a_59_75# VNB sky130_fd_pr__nfet_01v8 ad=0.0567 pd=0.69 as=0.1176 ps=1.4 w=0.42 l=0.15
.ends

.subckt sky130_fd_sc_hd__or2_1 A B VGND VNB VPB VPWR X
X0 VGND A a_68_297# VNB sky130_fd_pr__nfet_01v8 ad=0.10025 pd=0.985 as=0.0567 ps=0.69 w=0.42 l=0.15
X1 a_68_297# B VGND VNB sky130_fd_pr__nfet_01v8 ad=0.0567 pd=0.69 as=0.1092 ps=1.36 w=0.42 l=0.15
X2 X a_68_297# VGND VNB sky130_fd_pr__nfet_01v8 ad=0.169 pd=1.82 as=0.10025 ps=0.985 w=0.65 l=0.15
X3 VPWR A a_150_297# VPB sky130_fd_pr__pfet_01v8_hvt ad=0.14575 pd=1.335 as=0.0441 ps=0.63 w=0.42 l=0.15
X4 X a_68_297# VPWR VPB sky130_fd_pr__pfet_01v8_hvt ad=0.34 pd=2.68 as=0.14575 ps=1.335 w=1 l=0.15
X5 a_150_297# B a_68_297# VPB sky130_fd_pr__pfet_01v8_hvt ad=0.0441 pd=0.63 as=0.1092 ps=1.36 w=0.42 l=0.15
.ends

.subckt adder4_layout
Xsky130_fd_sc_hd__xor2_1_3 sky130_fd_sc_hd__xor2_1_3/A sky130_fd_sc_hd__xor2_1_3/B
+ sky130_fd_sc_hd__xor2_1_3/VGND SUB sky130_fd_sc_hd__xor2_1_3/VPB sky130_fd_sc_hd__xor2_1_3/VPWR
+ sky130_fd_sc_hd__xor2_1_3/X sky130_fd_sc_hd__xor2_1
Xsky130_fd_sc_hd__xor2_1_4 sky130_fd_sc_hd__xor2_1_4/A sky130_fd_sc_hd__xor2_1_4/B
+ sky130_fd_sc_hd__xor2_1_4/VGND SUB sky130_fd_sc_hd__xor2_1_4/VPB sky130_fd_sc_hd__xor2_1_4/VPWR
+ sky130_fd_sc_hd__xor2_1_4/X sky130_fd_sc_hd__xor2_1
Xsky130_fd_sc_hd__xor2_1_5 sky130_fd_sc_hd__xor2_1_5/A sky130_fd_sc_hd__xor2_1_5/B
+ sky130_fd_sc_hd__xor2_1_5/VGND SUB sky130_fd_sc_hd__xor2_1_5/VPB sky130_fd_sc_hd__xor2_1_5/VPWR
+ sky130_fd_sc_hd__xor2_1_5/X sky130_fd_sc_hd__xor2_1
Xsky130_fd_sc_hd__xor2_1_6 sky130_fd_sc_hd__xor2_1_6/A sky130_fd_sc_hd__xor2_1_6/B
+ sky130_fd_sc_hd__xor2_1_6/VGND SUB sky130_fd_sc_hd__xor2_1_6/VPB sky130_fd_sc_hd__xor2_1_6/VPWR
+ sky130_fd_sc_hd__xor2_1_6/X sky130_fd_sc_hd__xor2_1
Xsky130_fd_sc_hd__xor2_1_7 sky130_fd_sc_hd__xor2_1_7/A sky130_fd_sc_hd__xor2_1_7/B
+ sky130_fd_sc_hd__xor2_1_7/VGND SUB sky130_fd_sc_hd__xor2_1_7/VPB sky130_fd_sc_hd__xor2_1_7/VPWR
+ sky130_fd_sc_hd__xor2_1_7/X sky130_fd_sc_hd__xor2_1
Xsky130_fd_sc_hd__and2_1_0 sky130_fd_sc_hd__and2_1_0/A sky130_fd_sc_hd__and2_1_0/B
+ sky130_fd_sc_hd__and2_1_0/VGND SUB sky130_fd_sc_hd__and2_1_0/VPB sky130_fd_sc_hd__and2_1_0/VPWR
+ sky130_fd_sc_hd__and2_1_0/X sky130_fd_sc_hd__and2_1
Xsky130_fd_sc_hd__and2_1_1 sky130_fd_sc_hd__and2_1_1/A sky130_fd_sc_hd__and2_1_1/B
+ sky130_fd_sc_hd__and2_1_1/VGND SUB sky130_fd_sc_hd__and2_1_1/VPB sky130_fd_sc_hd__and2_1_1/VPWR
+ sky130_fd_sc_hd__and2_1_1/X sky130_fd_sc_hd__and2_1
Xsky130_fd_sc_hd__and2_1_3 sky130_fd_sc_hd__and2_1_3/A sky130_fd_sc_hd__and2_1_3/B
+ sky130_fd_sc_hd__and2_1_3/VGND SUB sky130_fd_sc_hd__and2_1_3/VPB sky130_fd_sc_hd__and2_1_3/VPWR
+ sky130_fd_sc_hd__and2_1_3/X sky130_fd_sc_hd__and2_1
Xsky130_fd_sc_hd__and2_1_2 sky130_fd_sc_hd__and2_1_2/A sky130_fd_sc_hd__and2_1_2/B
+ sky130_fd_sc_hd__and2_1_2/VGND SUB sky130_fd_sc_hd__and2_1_2/VPB sky130_fd_sc_hd__and2_1_2/VPWR
+ sky130_fd_sc_hd__and2_1_2/X sky130_fd_sc_hd__and2_1
Xsky130_fd_sc_hd__and2_1_4 sky130_fd_sc_hd__and2_1_4/A sky130_fd_sc_hd__and2_1_4/B
+ sky130_fd_sc_hd__and2_1_4/VGND SUB sky130_fd_sc_hd__and2_1_4/VPB sky130_fd_sc_hd__and2_1_4/VPWR
+ sky130_fd_sc_hd__and2_1_4/X sky130_fd_sc_hd__and2_1
Xsky130_fd_sc_hd__and2_1_5 sky130_fd_sc_hd__and2_1_5/A sky130_fd_sc_hd__and2_1_5/B
+ sky130_fd_sc_hd__and2_1_5/VGND SUB sky130_fd_sc_hd__and2_1_5/VPB sky130_fd_sc_hd__and2_1_5/VPWR
+ sky130_fd_sc_hd__and2_1_5/X sky130_fd_sc_hd__and2_1
Xsky130_fd_sc_hd__or2_1_0 sky130_fd_sc_hd__or2_1_0/A sky130_fd_sc_hd__or2_1_0/B sky130_fd_sc_hd__or2_1_0/VGND
+ SUB sky130_fd_sc_hd__or2_1_0/VPB sky130_fd_sc_hd__or2_1_0/VPWR sky130_fd_sc_hd__or2_1_0/X
+ sky130_fd_sc_hd__or2_1
Xsky130_fd_sc_hd__or2_1_1 sky130_fd_sc_hd__or2_1_1/A sky130_fd_sc_hd__or2_1_1/B sky130_fd_sc_hd__or2_1_1/VGND
+ SUB sky130_fd_sc_hd__or2_1_1/VPB sky130_fd_sc_hd__or2_1_1/VPWR sky130_fd_sc_hd__or2_1_1/X
+ sky130_fd_sc_hd__or2_1
Xsky130_fd_sc_hd__and2_1_6 sky130_fd_sc_hd__and2_1_6/A sky130_fd_sc_hd__and2_1_6/B
+ sky130_fd_sc_hd__and2_1_6/VGND SUB sky130_fd_sc_hd__and2_1_6/VPB sky130_fd_sc_hd__and2_1_6/VPWR
+ sky130_fd_sc_hd__and2_1_6/X sky130_fd_sc_hd__and2_1
Xsky130_fd_sc_hd__or2_1_2 sky130_fd_sc_hd__or2_1_2/A sky130_fd_sc_hd__or2_1_2/B sky130_fd_sc_hd__or2_1_2/VGND
+ SUB sky130_fd_sc_hd__or2_1_2/VPB sky130_fd_sc_hd__or2_1_2/VPWR sky130_fd_sc_hd__or2_1_2/X
+ sky130_fd_sc_hd__or2_1
Xsky130_fd_sc_hd__and2_1_7 sky130_fd_sc_hd__and2_1_7/A sky130_fd_sc_hd__and2_1_7/B
+ sky130_fd_sc_hd__and2_1_7/VGND SUB sky130_fd_sc_hd__and2_1_7/VPB sky130_fd_sc_hd__and2_1_7/VPWR
+ sky130_fd_sc_hd__and2_1_7/X sky130_fd_sc_hd__and2_1
Xsky130_fd_sc_hd__or2_1_3 sky130_fd_sc_hd__or2_1_3/A sky130_fd_sc_hd__or2_1_3/B sky130_fd_sc_hd__or2_1_3/VGND
+ SUB sky130_fd_sc_hd__or2_1_3/VPB sky130_fd_sc_hd__or2_1_3/VPWR sky130_fd_sc_hd__or2_1_3/X
+ sky130_fd_sc_hd__or2_1
Xsky130_fd_sc_hd__xor2_1_0 sky130_fd_sc_hd__xor2_1_0/A sky130_fd_sc_hd__xor2_1_0/B
+ sky130_fd_sc_hd__xor2_1_0/VGND SUB sky130_fd_sc_hd__xor2_1_0/VPB sky130_fd_sc_hd__xor2_1_0/VPWR
+ sky130_fd_sc_hd__xor2_1_0/X sky130_fd_sc_hd__xor2_1
Xsky130_fd_sc_hd__xor2_1_1 sky130_fd_sc_hd__xor2_1_1/A sky130_fd_sc_hd__xor2_1_1/B
+ sky130_fd_sc_hd__xor2_1_1/VGND SUB sky130_fd_sc_hd__xor2_1_1/VPB sky130_fd_sc_hd__xor2_1_1/VPWR
+ sky130_fd_sc_hd__xor2_1_1/X sky130_fd_sc_hd__xor2_1
Xsky130_fd_sc_hd__xor2_1_2 sky130_fd_sc_hd__xor2_1_2/A sky130_fd_sc_hd__xor2_1_2/B
+ sky130_fd_sc_hd__xor2_1_2/VGND SUB sky130_fd_sc_hd__xor2_1_2/VPB sky130_fd_sc_hd__xor2_1_2/VPWR
+ sky130_fd_sc_hd__xor2_1_2/X sky130_fd_sc_hd__xor2_1
.ends
