* Standalone CMOS NAND gate test
.lib "/home/kbvar/open_pdks/sky130/sky130A/libs.tech/ngspice/sky130.lib.spice" tt

.subckt NAND2 A B Y VDD VSS
XMP1 Y A VDD VDD sky130_fd_pr__pfet_01v8 L=0.15 W=1
XMP2 Y B VDD VDD sky130_fd_pr__pfet_01v8 L=0.15 W=1
XMN1 Y A N1 VSS sky130_fd_pr__nfet_01v8 L=0.15 W=1
XMN2 N1 B VSS VSS sky130_fd_pr__nfet_01v8 L=0.15 W=1
.ends NAND2

VDD VDD 0 1.8
VA A 0 PULSE(0 1.8 5n 0.1n 0.1n 5n 10n)
VB B 0 PULSE(0 1.8 10n 0.1n 0.1n 10n 20n)

X1 A B Y VDD 0 NAND2

.control
tran 0.1n 20n
meas tran Y00 FIND v(Y) AT=2.5n
meas tran Y10 FIND v(Y) AT=7.5n
meas tran Y01 FIND v(Y) AT=12.5n
meas tran Y11 FIND v(Y) AT=17.5n
.endc
.end
