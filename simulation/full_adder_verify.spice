* CMOS Full Adder - 8 combination verification
.lib "/home/kbvar/open_pdks/sky130/sky130A/libs.tech/ngspice/sky130.lib.spice" tt

.subckt NAND2 A B Y VDD VSS
XMP1 Y A VDD VDD sky130_fd_pr__pfet_01v8 L=0.15 W=1
XMP2 Y B VDD VDD sky130_fd_pr__pfet_01v8 L=0.15 W=1
XMN1 Y A N1 VSS sky130_fd_pr__nfet_01v8 L=0.15 W=1
XMN2 N1 B VSS VSS sky130_fd_pr__nfet_01v8 L=0.15 W=1
.ends NAND2

.subckt XOR2 A B Y VDD VSS
X1 A B N1 VDD VSS NAND2
X2 A N1 N2 VDD VSS NAND2
X3 B N1 N3 VDD VSS NAND2
X4 N2 N3 Y VDD VSS NAND2
.ends XOR2

.subckt FULL_ADDER A B Cin Sum Cout VDD VSS
XOR_A A B X1 VDD VSS XOR2
XOR_B X1 Cin Sum VDD VSS XOR2
XAND1 A B N1 VDD VSS NAND2
XAND2 X1 Cin N2 VDD VSS NAND2
XOR_C N1 N2 Cout VDD VSS NAND2
.ends FULL_ADDER

VDD VDD 0 1.8
VA A 0 PULSE(0 1.8 16n 0.1n 0.1n 16n 32n)
VB B 0 PULSE(0 1.8 8n 0.1n 0.1n 8n 16n)
VC Cin 0 PULSE(0 1.8 4n 0.1n 0.1n 4n 8n)

XFA A B Cin Sum Cout VDD 0 FULL_ADDER

.control
tran 0.1n 32n
meas tran S000 FIND v(Sum) AT=2n
meas tran C000 FIND v(Cout) AT=2n
meas tran S001 FIND v(Sum) AT=6n
meas tran C001 FIND v(Cout) AT=6n
meas tran S010 FIND v(Sum) AT=10n
meas tran C010 FIND v(Cout) AT=10n
meas tran S011 FIND v(Sum) AT=14n
meas tran C011 FIND v(Cout) AT=14n
meas tran S100 FIND v(Sum) AT=18n
meas tran C100 FIND v(Cout) AT=18n
meas tran S101 FIND v(Sum) AT=22n
meas tran C101 FIND v(Cout) AT=22n
meas tran S110 FIND v(Sum) AT=26n
meas tran C110 FIND v(Cout) AT=26n
meas tran S111 FIND v(Sum) AT=30n
meas tran C111 FIND v(Cout) AT=30n
.endc
.end
