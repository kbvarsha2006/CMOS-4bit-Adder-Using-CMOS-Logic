* 4-bit CMOS Ripple Carry Adder - Sky130

.lib "/home/kbvar/open_pdks/sky130/sky130A/libs.tech/ngspice/sky130.lib.spice" tt

.subckt NAND2 A B Y VDD VSS
XMP1 Y A VDD VDD sky130_fd_pr__pfet_01v8 L=0.15 W=1
XMP2 Y B VDD VDD sky130_fd_pr__pfet_01v8 L=0.15 W=1
XMN1 Y A N1 VSS sky130_fd_pr__nfet_01v8 L=0.15 W=1
XMN2 N1 B VSS VSS sky130_fd_pr__nfet_01v8 L=0.15 W=1
.ends NAND2

.subckt XOR2 A B Y VDD VSS
X1 A B N1 VDD VSS NAND2
X2 A N1 N2 VDD VSS NAND2
X3 B N1 N3 VDD VSS NAND2
X4 N2 N3 Y VDD VSS NAND2
.ends XOR2

.subckt FULL_ADDER A B Cin Sum Cout VDD VSS
XOR_A A B X1 VDD VSS XOR2
XOR_B X1 Cin Sum VDD VSS XOR2
XAND1 A B N1 VDD VSS NAND2
XAND2 X1 Cin N2 VDD VSS NAND2
XOR_C N1 N2 Cout VDD VSS NAND2
.ends FULL_ADDER

* 4-bit ripple carry adder
.subckt ADDER4 A0 A1 A2 A3 B0 B1 B2 B3 Cin S0 S1 S2 S3 Cout VDD VSS
XFA0 A0 B0 Cin S0 C1 VDD VSS FULL_ADDER
XFA1 A1 B1 C1 S1 C2 VDD VSS FULL_ADDER
XFA2 A2 B2 C2 S2 C3 VDD VSS FULL_ADDER
XFA3 A3 B3 C3 S3 Cout VDD VSS FULL_ADDER
.ends ADDER4

* Testbench: 3 + 5 = 8
VDD VDD 0 1.8
VA0 A0 0 1.8
VA1 A1 0 1.8
VA2 A2 0 1.8
VA3 A3 0 1.8
VB0 B0 0 1.8
VB1 B1 0 1.8
VB2 B2 0 1.8
VB3 B3 0 1.8
VCIN Cin 0 1.8

XADD A0 A1 A2 A3 B0 B1 B2 B3 Cin S0 S1 S2 S3 Cout VDD 0 ADDER4

.control
op
print V(S0) V(S1) V(S2) V(S3) V(Cout)
.endc

.end
