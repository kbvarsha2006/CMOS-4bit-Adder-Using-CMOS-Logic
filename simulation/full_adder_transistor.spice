* Transistor-Level CMOS Full Adder - Sky130

.lib "/home/kbvar/open_pdks/sky130/sky130A/libs.tech/ngspice/sky130.lib.spice" tt

* CMOS NAND Gate
.subckt NAND2 A B Y VDD VSS
XMP1 Y A VDD VDD sky130_fd_pr__pfet_01v8 L=0.15 W=1
XMP2 Y B VDD VDD sky130_fd_pr__pfet_01v8 L=0.15 W=1
XMN1 Y A N1 VSS sky130_fd_pr__nfet_01v8 L=0.15 W=1
XMN2 N1 B VSS VSS sky130_fd_pr__nfet_01v8 L=0.15 W=1
.ends NAND2

* CMOS XOR Gate
.subckt XOR2 A B Y VDD VSS
X1 A B N1 VDD VSS NAND2
X2 A N1 N2 VDD VSS NAND2
X3 B N1 N3 VDD VSS NAND2
X4 N2 N3 Y VDD VSS NAND2
.ends XOR2

* CMOS Full Adder
.subckt FULL_ADDER A B Cin Sum Cout VDD VSS
XOR_A A B X1 VDD VSS XOR2
XOR_B X1 Cin Sum VDD VSS XOR2
XAND1 A B N1 VDD VSS NAND2
XAND2 X1 Cin N2 VDD VSS NAND2
XOR_C N1 N2 Cout VDD VSS NAND2
.ends FULL_ADDER

* Power supplies and inputs
VDD VDD 0 1.8
VA A 0 PULSE(0 1.8 4n 0.1n 0.1n 4n 8n)
VB B 0 PULSE(0 1.8 8n 0.1n 0.1n 8n 16n)
VC Cin 0 PULSE(0 1.8 16n 0.1n 0.1n 16n 32n)

* Full Adder instance
XFA A B Cin Sum Cout VDD 0 FULL_ADDER

.control
tran 0.1n 33n
print V(A) V(B) V(Cin) V(Sum) V(Cout)
.endc

.end
